* Auto-generated testbench for decoupling analysis: +3V3_MAIN rail
* 7 capacitor(s) in parallel, series R-L-C model
* Model: ESR/ESL from pdn_impedance (package-based)

R_esr_C12 rail n_esr_0 21.3m
L_par_C12 n_esr_0 n_lpar_0 700p
C12 n_lpar_0 0 22u
R_esr_C13 rail n_esr_1 21.3m
L_par_C13 n_esr_1 n_lpar_1 700p
C13 n_lpar_1 0 22u
R_esr_C40 rail n_esr_2 316.2m
L_par_C40 n_esr_2 n_lpar_2 700p
C40 n_lpar_2 0 100n
R_esr_C81 rail n_esr_3 31.6m
L_par_C81 n_esr_3 n_lpar_3 700p
C81 n_lpar_3 0 10u
R_esr_C82 rail n_esr_4 316.2m
L_par_C82 n_esr_4 n_lpar_4 700p
C82 n_lpar_4 0 100n
R_esr_C90 rail n_esr_5 31.6m
L_par_C90 n_esr_5 n_lpar_5 700p
C90 n_lpar_5 0 10u
R_esr_C91 rail n_esr_6 316.2m
L_par_C91 n_esr_6 n_lpar_6 700p
C91 n_lpar_6 0 100n

* 1A AC current source into the rail node — V(rail) = Z(f)
IAC 0 rail DC 0 AC 1

.control
ac dec 200 100 100Meg
let z_mag = vm(rail)
meas ac z_min min z_mag
meas ac f_at_zmin when z_mag=z_min
meas ac z_at_1M find vm(rail) at=1Meg
meas ac z_at_100k find vm(rail) at=100k
echo "z_min=$&z_min f_at_zmin=$&f_at_zmin z_at_1M=$&z_at_1M z_at_100k=$&z_at_100k n_caps=7" > /Users/tapir/Development/CadenzaOS/hardware/rev-a/product-d1/review-v50-final-20260721/spice-work/decoupling_C12_C13_C40_C81_C82.out
quit
.endc

.end
