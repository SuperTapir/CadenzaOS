* Auto-generated testbench for inrush analysis: U3 (switching)
* Output: 3.3V, 64.3µF total capacitance
* Soft-start: 1.0ms ramp

* Voltage source with linear ramp (soft-start) — 10us delay before ramp
Vreg ramp 0 PWL(0 0 10u 0 1.01m 3.3)
* Regulator output impedance
Rout ramp out 10m

* Output capacitors
C12 out 0 22u
C13 out 0 22u
C40 out 0 100n
C81 out 0 10u
C82 out 0 100n
C90 out 0 10u
C91 out 0 100n

.control
tran 2u 3m
let i_out = abs(i(Rout))
let i_peak = vecmax(i_out)
let t_peak = i_out[vecmin(abs(i_out - i_peak))]
meas tran v_settled find v(out) at=2.7m
echo "i_peak=$&i_peak t_peak=$&t_peak v_settled=$&v_settled v_target=3.3 r_out=0.01" > /Users/tapir/Development/CadenzaOS/hardware/rev-a/product-d1/review-v50-final-20260721/spice-work/inrush_idx0.out
quit
.endc

.end
