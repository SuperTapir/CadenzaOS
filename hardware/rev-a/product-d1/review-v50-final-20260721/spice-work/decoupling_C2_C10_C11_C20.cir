* Auto-generated testbench for decoupling analysis: VSYS rail
* 4 capacitor(s) in parallel, series R-L-C model
* Model: ESR/ESL from pdn_impedance (package-based)

R_esr_C2 rail n_esr_0 31.6m
L_par_C2 n_esr_0 n_lpar_0 700p
C2 n_lpar_0 0 10u
R_esr_C10 rail n_esr_1 31.6m
L_par_C10 n_esr_1 n_lpar_1 700p
C10 n_lpar_1 0 10u
R_esr_C11 rail n_esr_2 31.6m
L_par_C11 n_esr_2 n_lpar_2 700p
C11 n_lpar_2 0 10u
R_esr_C20 rail n_esr_3 31.6m
L_par_C20 n_esr_3 n_lpar_3 700p
C20 n_lpar_3 0 10u

* 1A AC current source into the rail node — V(rail) = Z(f)
IAC 0 rail DC 0 AC 1

.control
ac dec 200 100 100Meg
let z_mag = vm(rail)
meas ac z_min min z_mag
meas ac f_at_zmin when z_mag=z_min
meas ac z_at_1M find vm(rail) at=1Meg
meas ac z_at_100k find vm(rail) at=100k
echo "z_min=$&z_min f_at_zmin=$&f_at_zmin z_at_1M=$&z_at_1M z_at_100k=$&z_at_100k n_caps=4" > /Users/tapir/Development/CadenzaOS/hardware/rev-a/product-d1/review-v50-final-20260721/spice-work/decoupling_C2_C10_C11_C20.out
quit
.endc

.end
