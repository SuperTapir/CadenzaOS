* Auto-generated testbench for voltage divider: R10/R11
* Expected Vout = 3.3 * 0.241935 = 0.7984 V
* Model: ideal passives (exact, unloaded)

VIN _3V3_MAIN 0 DC 3.3
R10 _3V3_MAIN FB_3V3 470k
R11 FB_3V3 0 150k

.control
op
let vout_sim = v(FB_3V3)
let error_pct = abs(vout_sim - 0.7983855) / 0.7983855 * 100
echo "vout_sim=$&vout_sim error_pct=$&error_pct expected=0.7983855" > /Users/tapir/Development/CadenzaOS/hardware/rev-a/product-d1/review-v50-final-20260721/spice-work/voltage-divider_R10_R11.out
quit
.endc

.end
