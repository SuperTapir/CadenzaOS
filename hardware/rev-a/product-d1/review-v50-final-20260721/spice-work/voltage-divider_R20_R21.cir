* Auto-generated testbench for voltage divider: R20/R21
* Expected Vout = 5.0 * 0.120192 = 0.6010 V
* Model: ideal passives (exact, unloaded)

VIN _5V_MEDIA 0 DC 5.0
R20 _5V_MEDIA FB_5V 732k
R21 FB_5V 0 100k

.control
op
let vout_sim = v(FB_5V)
let error_pct = abs(vout_sim - 0.6009599999999999) / 0.6009599999999999 * 100
echo "vout_sim=$&vout_sim error_pct=$&error_pct expected=0.6009599999999999" > /Users/tapir/Development/CadenzaOS/hardware/rev-a/product-d1/review-v50-final-20260721/spice-work/voltage-divider_R20_R21.out
quit
.endc

.end
