* Auto-generated testbench for RC filter: R80/C80
* Type: low-pass, expected fc = 15.9 Hz
* Model: ideal passives (exact for RC)

R80 _3V3_MAIN ESP_EN 10k

C80 ESP_EN 0 1u

* AC stimulus
VAC _3V3_MAIN 0 DC 0 AC 1

.control
ac dec 100 159.2m 1.592k
meas ac fc_sim when vdb(ESP_EN)=-3
meas ac phase_fc find vp(ESP_EN) at=fc_sim
echo "fc_sim=$&fc_sim phase_fc=$&phase_fc has_parasitics=0" > /Users/tapir/Development/CadenzaOS/hardware/rev-a/product-d1/review-v50-final-20260721/spice-work/rc-filter_R80_C80.out
quit
.endc

.end
