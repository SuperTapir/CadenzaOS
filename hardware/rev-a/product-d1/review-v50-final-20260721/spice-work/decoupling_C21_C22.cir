* Auto-generated testbench for decoupling analysis: +5V_MEDIA rail
* 2 capacitor(s) in parallel, series R-L-C model
* Model: ESR/ESL from pdn_impedance (package-based)

R_esr_C21 rail n_esr_0 21.3m
L_par_C21 n_esr_0 n_lpar_0 700p
C21 n_lpar_0 0 22u
R_esr_C22 rail n_esr_1 21.3m
L_par_C22 n_esr_1 n_lpar_1 700p
C22 n_lpar_1 0 22u

* 1A AC current source into the rail node — V(rail) = Z(f)
IAC 0 rail DC 0 AC 1

.control
ac dec 200 100 100Meg
let z_mag = vm(rail)
meas ac z_min min z_mag
meas ac f_at_zmin when z_mag=z_min
meas ac z_at_1M find vm(rail) at=1Meg
meas ac z_at_100k find vm(rail) at=100k
echo "z_min=$&z_min f_at_zmin=$&f_at_zmin z_at_1M=$&z_at_1M z_at_100k=$&z_at_100k n_caps=2" > /Users/tapir/Development/CadenzaOS/hardware/rev-a/product-d1/review-v50-final-20260721/spice-work/decoupling_C21_C22.out
quit
.endc

.end
