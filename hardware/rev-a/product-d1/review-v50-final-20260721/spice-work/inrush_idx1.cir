* Auto-generated testbench for inrush analysis: U4 (switching)
* Output: 4.95V, 44.0µF total capacitance
* Soft-start: 1.0ms ramp

* Voltage source with linear ramp (soft-start) — 10us delay before ramp
Vreg ramp 0 PWL(0 0 10u 0 1.01m 4.95)
* Regulator output impedance
Rout ramp out 10m

* Output capacitors
C21 out 0 22u
C22 out 0 22u

.control
tran 2u 3m
let i_out = abs(i(Rout))
let i_peak = vecmax(i_out)
let t_peak = i_out[vecmin(abs(i_out - i_peak))]
meas tran v_settled find v(out) at=2.7m
echo "i_peak=$&i_peak t_peak=$&t_peak v_settled=$&v_settled v_target=4.95 r_out=0.01" > /Users/tapir/Development/CadenzaOS/hardware/rev-a/product-d1/review-v50-final-20260721/spice-work/inrush_idx1.out
quit
.endc

.end
