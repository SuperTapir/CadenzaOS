* Auto-generated testbench for regulator feedback: U4
* Divider: R20/R21, ratio=0.1202
* Expected Vout=5.0V, Vfb=0.6010V (Vref=0.595V)
* Topology: standard
* Model: ideal passives (exact for DC divider)

VIN out_rail 0 DC 5.0
R20 out_rail fb_net 732k
R21 fb_net 0 100k

.control
op
let vfb_sim = v(fb_net)
let expected = 0.6009599999999999
let error_pct = abs(vfb_sim - expected) / expected * 100
echo "vfb_sim=$&vfb_sim error_pct=$&error_pct expected=0.6009599999999999 vin=5.0 vref=0.595" > /Users/tapir/Development/CadenzaOS/hardware/rev-a/product-d1/review-v50-final-20260721/spice-work/regulator-feedback_U4_R20_R21.out
quit
.endc

.end
